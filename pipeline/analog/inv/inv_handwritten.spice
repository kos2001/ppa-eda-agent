* sky130 CMOS inverter — the first transistor-level cell in this repo.
*
* %PDK_LIB% is substituted by custom_bridge.bind_corner() with the real
* model library and the corner's section name, so the same deck runs at
* tt/ss/ff without being edited (and so gf180's `typical` section name
* does not have to be remembered here).
%PDK_LIB%

.param VDD=1.8
.param WP=1.0
.param WN=0.5
.param LCH=0.15

Vdd  vdd 0 {VDD}
Vin  in  0 pulse(0 {VDD} 1n 100p 100p 2n 4n)
XM1  out in vdd vdd sky130_fd_pr__pfet_01v8 L={LCH} W={WP}
XM2  out in 0   0   sky130_fd_pr__nfet_01v8 L={LCH} W={WN}
Cl   out 0 10f

.control
* DC transfer: where the inverter actually switches. FALL, not RISE —
* v(out) falls as v(in) rises, and `rise=1` here fails with
* "out of interval" while still exiting 0. Numbers here are literal:
* .param braces are a netlist-side feature, and inside .control ngspice
* turns `{VDD/2}` into an unresolvable `vexprint` vector and then reports
* the measure as failed while still exiting 0.
dc Vin 0 1.8 0.01
meas dc vtrip WHEN v(out)=0.9 FALL=1

tran 10p 8n
meas tran tphl TRIG v(in) VAL=0.9 RISE=1 TARG v(out) VAL=0.9 FALL=1
meas tran tplh TRIG v(in) VAL=0.9 FALL=1 TARG v(out) VAL=0.9 RISE=1
meas tran ivdd_avg AVG i(Vdd) FROM=0 TO=8n
quit
.endc
.end
