SKY130 PVT transistor equivalence
.lib "/mnt/c/Users/김오석/claude-work/ppa-eda-agent/pdk/sky130A/libs.tech/ngspice/sky130.lib.spice" ss
.temp 100
vd d 0 1.6
vg g 0 1.6
x1 d g 0 0 sky130_fd_pr__nfet_01v8 w=1.26 l=.15
x2 d g 0 0 sky130_fd_pr__nfet_01v8 w=.42 l=.5
.options KLU
.control
set numdgt=15
op
print i(vd)
quit
.endc
.end
